Metantenna 50-ohm preselector; source voltage 2 V gives unity matched S21
Vsrc src 0 AC 2
Rsrc src a 50
Rload out 0 50
Rchp1 a chp1r 0.03
Lchp1 chp1r chp1l 0.5n
Cchp1 chp1l b 180.0p
Rlhp b lhpr 0.9873576911282208
Llhp lhpr 0 220.0n
Clhppar b 0 0.1p
Rchp2 b chp2r 0.03
Lchp2 chp2r chp2l 0.5n
Cchp2 chp2l c 180.0p
Rclp1 c clp1r 0.03
Lclp1 clp1r clp1l 0.5n
Cclp1 clp1l 0 18.0p
Rllp2 c llp2r 0.25132741228718347
Lllp2 llp2r d 56.0n
Cllp2par c d 0.1p
Rclp2 c clp2r 0.03
Lclp2 clp2r clp2l 0.5n
Cclp2 clp2l d 56.0p
Rclp3 d clp3r 0.03
Lclp3 clp3r clp3l 0.5n
Cclp3 clp3l 0 51.0p
Rllp4 d llp4r 0.30518328634872277
Lllp4 llp4r out 68.0n
Cllp4par d out 0.1p
Rclp4 d clp4r 0.03
Lclp4 clp4r clp4l 0.5n
Cclp4 clp4l out 36.0p
Rclp5 out clp5r 0.03
Lclp5 clp5r clp5l 0.5n
Cclp5 clp5l 0 15.0p
Cpada a 0 0.3p
Cpadb b 0 0.3p
Cpadc c 0 0.3p
Cpadd d 0 0.3p
Cpadout out 0 0.3p
.control
set wr_singlescale
set wr_vecnames
ac lin 3991 1Meg 400Meg
let transfer = v(out)
let reflection = v(a)-1
wrdata response.txt real(transfer) imag(transfer) real(reflection) imag(reflection)
quit
.endc
.end
